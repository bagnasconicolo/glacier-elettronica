* sim_3canali.cir - scheda a 3 canali intera (GENERATO da sim_3canali.py)
.include riv_cosmici_modelli.lib
.param VIN=5 V1_POS=0.76 V2_POS=0.92
.param VBD=32.5 G12=7.3Meg VOV=5.94
.param QPE={1.602e-19*G12*VOV/12}
.param CSIPM=160p TAUSIPM=55n
R1 FB 0 10k
R2 FB 0 68k
R3 VOUT40 FB 255k
R104 INV1 0 1.2k
R204 INV2 0 1.2k
R304 INV3 0 1.2k
R105 INV1 VREG381 15k
R205 INV2 VREG382 15k
R305 INV3 VREG383 15k
R106 VSET1 0 100k
R206 VSET2 0 100k
R306 VSET3 0 100k
R107 VADJ_LO1 0 27k
R207 VADJ_LO2 0 27k
R307 VADJ_LO3 0 27k
R108 VREG381 BIAS1 1k
R208 VREG382 BIAS2 1k
R308 VREG383 BIAS3 1k
R109 Q1B1 0 1.8k
R209 Q1B2 0 1.8k
R309 Q1B3 0 1.8k
R110 SIG_IN1 0 10k
R210 SIG_IN2 0 10k
R310 SIG_IN3 0 10k
R111 Q1B1 Q1C1 5.6k
R211 Q1B2 Q1C2 5.6k
R311 Q1B3 Q1C3 5.6k
R112 Q1C1 V3V3 1k
R212 Q1C2 V3V3 1k
R312 Q1C3 V3V3 1k
R113 Q2E1 V3V3 560
R213 Q2E2 V3V3 560
R313 Q2E3 V3V3 560
R114 Q2C1 0 1k
R214 Q2C2 0 1k
R314 Q2C3 0 1k
R115 CMP_IN1 0 1k
R215 CMP_IN2 0 1k
R315 CMP_IN3 0 1k
R116 LE1 0 1k
R216 LE2 0 1k
R316 LE3 0 1k
R117 TH1 TH_W1 470
R217 TH2 TH_W2 470
R317 TH3 TH_W3 470
R118 TH_LO1 0 10
R218 TH_LO2 0 10
R318 TH_LO3 0 10
R119 TH_HI1 V3V6 18k
R219 TH_HI2 V3V6 18k
R319 TH_HI3 V3V6 18k
R120 T5551 V3V3 100k
R220 T5552 V3V3 100k
R320 T5553 V3V3 100k
R121 LED_A1 LED_K1 82
R221 LED_A2 LED_K2 82
R321 LED_A3 LED_K3 82
R22 FB 0 220k
C1 VOUT40 FB 22p
C2 VOUT40 0 1u
C3 VOUT40 0 100n
C104 VSET1 0 100n
C204 VSET2 0 100n
C304 VSET3 0 100n
C106 BIAS1 0 100n
C206 BIAS2 0 100n
C306 BIAS3 0 100n
C107 SIG_IN1 Q1B1 10n
C207 SIG_IN2 Q1B2 10n
C307 SIG_IN3 Q1B3 10n
C109 LE1 CMP_Q1 100p
C209 LE2 CMP_Q2 100p
C309 LE3 CMP_Q3 100p
C111 Q2C1 CMP_IN1 10n
C211 Q2C2 CMP_IN2 10n
C311 Q2C3 CMP_IN3 10n
C121 T5551 0 100n
C221 T5552 0 100n
C321 T5553 0 100n
C22 V5 0 1u
CF101 V3V3 0 100n
CF201 V3V3 0 100n
CF301 V3V3 0 100n
CF102 V3V3 0 100n
CF202 V3V3 0 100n
CF302 V3V3 0 100n
CF4 V3V6 0 2.2u
CF105 V3V3 0 100n
CF205 V3V3 0 100n
CF305 V3V3 0 100n
CF106 CTL5551 0 100n
CF206 CTL5552 0 100n
CF306 CTL5553 0 100n
CF7 VREF_B 0 2.2u
CF8 V5 0 100n
CF9 V3V3 0 2.2u
L1 V5 L1_DCR 47u
RL1_DCR L1_DCR SW 0.5
DD101 VREF_B VADJ_HI1 1N4148
DD201 VREF_B VADJ_HI2 1N4148
DD301 VREF_B VADJ_HI3 1N4148
DD103 LED_K1 0 LED_ROSSO
DD203 LED_K2 0 LED_ROSSO
DD303 LED_K3 0 LED_ROSSO
QQ101 Q1C1 Q1B1 0 BFR93A
QQ201 Q1C2 Q1B2 0 BFR93A
QQ301 Q1C3 Q1B3 0 BFR93A
QQ102 Q2C1 Q1C1 Q2E1 MMBTH81
QQ202 Q2C2 Q1C2 Q2E2 MMBTH81
QQ302 Q2C3 Q1C3 Q2E3 MMBTH81
XU1 SW 0 FB V5 VOUT40 V5 LT3461
XU102 0 CMP_QB1 LED_A1 V3V3 CTL5551 T5551 T5551 V3V3 TLC555
XU202 0 CMP_QB2 LED_A2 V3V3 CTL5552 T5552 T5552 V3V3 TLC555
XU302 0 CMP_QB3 LED_A3 V3V3 CTL5553 T5553 T5553 V3V3 TLC555
XU103 CMP_IN1 TH1 0 LE1 0 CMP_Q1 CMP_QB1 V3V3 MAX961
XU203 CMP_IN2 TH2 0 LE2 0 CMP_Q2 CMP_QB2 V3V3 MAX961
XU303 CMP_IN3 TH3 0 LE3 0 CMP_Q3 CMP_QB3 V3V3 MAX961
XU5 V5 0 V5 NC_U5_4 V3V6 LP2985
XU6 V5 0 V3V3 0 MCP1825
XU7 V5 0 V5 NC_U7_4 VREF_B LP2985
XU108 NC_U108_1 INV1 VSET1 0 NC_U108_5 VREG381 VOUT40 NC_U108_8 LT1636
XU208 NC_U208_1 INV2 VSET2 0 NC_U208_5 VREG382 VOUT40 NC_U208_8 LT1636
XU308 NC_U308_1 INV3 VSET3 0 NC_U308_5 VREG383 VOUT40 NC_U308_8 LT1636
XV101 VADJ_LO1 VSET1 VADJ_HI1 POT R=10k POS={V1_POS}
XV201 VADJ_LO2 VSET2 VADJ_HI2 POT R=10k POS={V1_POS}
XV301 VADJ_LO3 VSET3 VADJ_HI3 POT R=10k POS={V1_POS}
XV102 TH_HI1 TH_W1 TH_LO1 POT R=10k POS={V2_POS}
XV202 TH_HI2 TH_W2 TH_LO2 POT R=10k POS={V2_POS}
XV302 TH_HI3 TH_W3 TH_LO3 POT R=10k POS={V2_POS}
XSIPM1 SIG_IN1 BIAS1 SIPM NPE1=250 T1=10.0m NPE2=250 T2=10.02m NPE3=150 T3=10.04m NPE4=25 T4=10.06m CSIPM={CSIPM} QPE={QPE} TAU={TAUSIPM}
XSIPM2 SIG_IN2 BIAS2 SIPM NPE1=150 T1=10.000002m NPE2=0 T2=10.02m NPE3=150 T3=10.04m NPE4=25 T4=10.060005m CSIPM={CSIPM} QPE={QPE} TAU={TAUSIPM}
XSIPM3 SIG_IN3 BIAS3 SIPM NPE1=80 T1=10.000004m NPE2=0 T2=10.02m NPE3=0 T3=10.04m NPE4=25 T4=10.06001m CSIPM={CSIPM} QPE={QPE} TAU={TAUSIPM}
VJ3 VIN_EXT 0 PWL(0 0 100u {VIN})
RJ3_CAVO VIN_EXT V5 0.05
XU109 NC_U109_1 CMP_Q1 0 BUF_Y1 V3V3 LVC1G17
XU209 NC_U209_1 CMP_Q2 0 BUF_Y2 V3V3 LVC1G17
XU309 NC_U309_1 CMP_Q3 0 BUF_Y3 V3V3 LVC1G17
CF110 V3V3 0 100n
CF210 V3V3 0 100n
CF310 V3V3 0 100n
R123 BUF_Y1 BUF_OUT1 33
R223 BUF_Y2 BUF_OUT2 33
R323 BUF_Y3 BUF_OUT3 33
CCAVO_J104 BUF_OUT1 0 100p
RSER_J104 BUF_OUT1 GPIO_J104 330
CRPI_J104 GPIO_J104 0 5p
RRPI_J104 GPIO_J104 0 50k
CCAVO_J204 BUF_OUT2 0 100p
RSER_J204 BUF_OUT2 GPIO_J204 330
CRPI_J204 GPIO_J204 0 5p
RRPI_J204 GPIO_J204 0 50k
CCAVO_J304 BUF_OUT3 0 100p
RSER_J304 BUF_OUT3 GPIO_J304 330
CRPI_J304 GPIO_J304 0 5p
RRPI_J304 GPIO_J304 0 50k
XU10 AND_IN2 0 AND_IN1 AND_Y V3V3 AND_IN3 LVC1G11
CF11 V3V3 0 100n
R30 AND_Y AND_OUT 33
CCAVO_J5 AND_OUT 0 100p
RSER_J5 AND_OUT GPIO_J5 330
CRPI_J5 GPIO_J5 0 5p
RRPI_J5 GPIO_J5 0 50k
RJP1 BUF_Y1 AND_IN1 0.01
R31 AND_IN1 V3V3 10k
RJP2 BUF_Y2 AND_IN2 0.01
R32 AND_IN2 V3V3 10k
RJP3 BUF_Y3 AND_IN3 0.01
R33 AND_IN3 V3V3 10k
R150 VREG381 MON1 1Meg
R151 MON1 0 43k
C150 MON1 0 100n
R250 VREG382 MON2 1Meg
R251 MON2 0 43k
C250 MON2 0 100n
R350 VREG383 MON3 1Meg
R351 MON3 0 43k
C350 MON3 0 100n
R40 VOUT40 MON4 1Meg
R41 MON4 0 43k
C40 MON4 0 100n
RU11_IN1 MON1 0 2.25Meg
RU11_IN3 MON2 0 2.25Meg
RU11_IN11 MON3 0 2.25Meg
RU11_IN13 MON4 0 2.25Meg
RU11_P5 0 0 1G
RU11_P6 V3V3 0 1G
RU11_P7 SDA_ADC 0 1G
RU11_P8 SCL_ADC 0 1G
RU11_P9 0 0 1G
RU11_P10 0 0 1G
CF12 V3V3 0 100n
R42 SDA_ADC I2C_SDA 100
R43 SCL_ADC I2C_SCL 100
R152 TH1 MONTH1 10k
C152 MONTH1 0 100n
R252 TH2 MONTH2 10k
C252 MONTH2 0 100n
R352 TH3 MONTH3 10k
C352 MONTH3 0 100n
RU12_IN1 MONTH1 0 2.25Meg
RU12_IN3 MONTH2 0 2.25Meg
RU12_IN11 MONTH3 0 2.25Meg
RU12_IN13 MONT 0 2.25Meg
RU12_P5 0 0 1G
RU12_P6 V3V3 0 1G
RU12_P7 SDA_ADC 0 1G
RU12_P8 SCL_ADC 0 1G
RU12_P9 V3V3 0 1G
RU12_P10 0 0 1G
CF13 V3V3 0 100n
R44 V3V3 MONT 22k
RT1 MONT 0 10k
C41 MONT 0 100n
.meas tran V_3V3 FIND V(V3V3) AT=9.9m
.meas tran V_3V6 FIND V(V3V6) AT=9.9m
.meas tran V_REFB FIND V(VREF_B) AT=9.9m
.meas tran V_OUT40 FIND V(VOUT40) AT=9.9m
.meas tran I_5V FIND I(VJ3) AT=9.9m
.meas tran V_BIAS1 FIND V(BIAS1) AT=9.9m
.meas tran V_TH1 FIND V(TH1) AT=9.9m
.meas tran CMP0_1 FIND V(CMP_IN1) AT=9.99m
.meas tran DBIAS1 PP V(BIAS1) FROM=9.999m TO=10.07m
.meas tran PK1_1 MAX V(CMP_IN1) FROM=9.999m TO=10.0045m
.meas tran MN1_1 MIN V(CMP_IN1) FROM=9.999m TO=10.0045m
.meas tran Q1_1 MAX V(CMP_Q1) FROM=9.999m TO=10.0045m
.meas tran G1_1 MAX V(GPIO_J104) FROM=9.999m TO=10.0045m
.meas tran PK2_1 MAX V(CMP_IN1) FROM=10.019m TO=10.0245m
.meas tran MN2_1 MIN V(CMP_IN1) FROM=10.019m TO=10.0245m
.meas tran Q2_1 MAX V(CMP_Q1) FROM=10.019m TO=10.0245m
.meas tran G2_1 MAX V(GPIO_J104) FROM=10.019m TO=10.0245m
.meas tran PK3_1 MAX V(CMP_IN1) FROM=10.039m TO=10.0445m
.meas tran MN3_1 MIN V(CMP_IN1) FROM=10.039m TO=10.0445m
.meas tran Q3_1 MAX V(CMP_Q1) FROM=10.039m TO=10.0445m
.meas tran G3_1 MAX V(GPIO_J104) FROM=10.039m TO=10.0445m
.meas tran PK4_1 MAX V(CMP_IN1) FROM=10.059m TO=10.0645m
.meas tran MN4_1 MIN V(CMP_IN1) FROM=10.059m TO=10.0645m
.meas tran Q4_1 MAX V(CMP_Q1) FROM=10.059m TO=10.0645m
.meas tran G4_1 MAX V(GPIO_J104) FROM=10.059m TO=10.0645m
.meas tran V_BIAS2 FIND V(BIAS2) AT=9.9m
.meas tran V_TH2 FIND V(TH2) AT=9.9m
.meas tran CMP0_2 FIND V(CMP_IN2) AT=9.99m
.meas tran DBIAS2 PP V(BIAS2) FROM=9.999m TO=10.07m
.meas tran PK1_2 MAX V(CMP_IN2) FROM=9.999m TO=10.0045m
.meas tran MN1_2 MIN V(CMP_IN2) FROM=9.999m TO=10.0045m
.meas tran Q1_2 MAX V(CMP_Q2) FROM=9.999m TO=10.0045m
.meas tran G1_2 MAX V(GPIO_J204) FROM=9.999m TO=10.0045m
.meas tran PK2_2 MAX V(CMP_IN2) FROM=10.019m TO=10.0245m
.meas tran MN2_2 MIN V(CMP_IN2) FROM=10.019m TO=10.0245m
.meas tran Q2_2 MAX V(CMP_Q2) FROM=10.019m TO=10.0245m
.meas tran G2_2 MAX V(GPIO_J204) FROM=10.019m TO=10.0245m
.meas tran PK3_2 MAX V(CMP_IN2) FROM=10.039m TO=10.0445m
.meas tran MN3_2 MIN V(CMP_IN2) FROM=10.039m TO=10.0445m
.meas tran Q3_2 MAX V(CMP_Q2) FROM=10.039m TO=10.0445m
.meas tran G3_2 MAX V(GPIO_J204) FROM=10.039m TO=10.0445m
.meas tran PK4_2 MAX V(CMP_IN2) FROM=10.059m TO=10.0645m
.meas tran MN4_2 MIN V(CMP_IN2) FROM=10.059m TO=10.0645m
.meas tran Q4_2 MAX V(CMP_Q2) FROM=10.059m TO=10.0645m
.meas tran G4_2 MAX V(GPIO_J204) FROM=10.059m TO=10.0645m
.meas tran V_BIAS3 FIND V(BIAS3) AT=9.9m
.meas tran V_TH3 FIND V(TH3) AT=9.9m
.meas tran CMP0_3 FIND V(CMP_IN3) AT=9.99m
.meas tran DBIAS3 PP V(BIAS3) FROM=9.999m TO=10.07m
.meas tran PK1_3 MAX V(CMP_IN3) FROM=9.999m TO=10.0045m
.meas tran MN1_3 MIN V(CMP_IN3) FROM=9.999m TO=10.0045m
.meas tran Q1_3 MAX V(CMP_Q3) FROM=9.999m TO=10.0045m
.meas tran G1_3 MAX V(GPIO_J304) FROM=9.999m TO=10.0045m
.meas tran PK2_3 MAX V(CMP_IN3) FROM=10.019m TO=10.0245m
.meas tran MN2_3 MIN V(CMP_IN3) FROM=10.019m TO=10.0245m
.meas tran Q2_3 MAX V(CMP_Q3) FROM=10.019m TO=10.0245m
.meas tran G2_3 MAX V(GPIO_J304) FROM=10.019m TO=10.0245m
.meas tran PK3_3 MAX V(CMP_IN3) FROM=10.039m TO=10.0445m
.meas tran MN3_3 MIN V(CMP_IN3) FROM=10.039m TO=10.0445m
.meas tran Q3_3 MAX V(CMP_Q3) FROM=10.039m TO=10.0445m
.meas tran G3_3 MAX V(GPIO_J304) FROM=10.039m TO=10.0445m
.meas tran PK4_3 MAX V(CMP_IN3) FROM=10.059m TO=10.0645m
.meas tran MN4_3 MIN V(CMP_IN3) FROM=10.059m TO=10.0645m
.meas tran Q4_3 MAX V(CMP_Q3) FROM=10.059m TO=10.0645m
.meas tran G4_3 MAX V(GPIO_J304) FROM=10.059m TO=10.0645m
.meas tran AND1 MAX V(GPIO_J5) FROM=9.999m TO=10.0045m
.meas tran WAND1 TRIG V(GPIO_J5) VAL=1.65 RISE=1 TD=9.999m TARG V(GPIO_J5) VAL=1.65 FALL=1 TD=9.999m
.meas tran WQ1_1 TRIG V(CMP_Q1) VAL=1.65 RISE=1 TD=9.999m TARG V(CMP_Q1) VAL=1.65 FALL=1 TD=9.999m
.meas tran DAND1 TRIG V(CMP_Q1) VAL=1.65 RISE=1 TD=9.999m TARG V(GPIO_J5) VAL=1.65 RISE=1 TD=9.999m
.meas tran AND2 MAX V(GPIO_J5) FROM=10.019m TO=10.0245m
.meas tran WAND2 TRIG V(GPIO_J5) VAL=1.65 RISE=1 TD=10.019m TARG V(GPIO_J5) VAL=1.65 FALL=1 TD=10.019m
.meas tran WQ2_1 TRIG V(CMP_Q1) VAL=1.65 RISE=1 TD=10.019m TARG V(CMP_Q1) VAL=1.65 FALL=1 TD=10.019m
.meas tran DAND2 TRIG V(CMP_Q1) VAL=1.65 RISE=1 TD=10.019m TARG V(GPIO_J5) VAL=1.65 RISE=1 TD=10.019m
.meas tran AND3 MAX V(GPIO_J5) FROM=10.039m TO=10.0445m
.meas tran WAND3 TRIG V(GPIO_J5) VAL=1.65 RISE=1 TD=10.039m TARG V(GPIO_J5) VAL=1.65 FALL=1 TD=10.039m
.meas tran WQ3_1 TRIG V(CMP_Q1) VAL=1.65 RISE=1 TD=10.039m TARG V(CMP_Q1) VAL=1.65 FALL=1 TD=10.039m
.meas tran DAND3 TRIG V(CMP_Q1) VAL=1.65 RISE=1 TD=10.039m TARG V(GPIO_J5) VAL=1.65 RISE=1 TD=10.039m
.meas tran AND4 MAX V(GPIO_J5) FROM=10.059m TO=10.0645m
.meas tran WAND4 TRIG V(GPIO_J5) VAL=1.65 RISE=1 TD=10.059m TARG V(GPIO_J5) VAL=1.65 FALL=1 TD=10.059m
.meas tran WQ4_1 TRIG V(CMP_Q1) VAL=1.65 RISE=1 TD=10.059m TARG V(CMP_Q1) VAL=1.65 FALL=1 TD=10.059m
.meas tran DAND4 TRIG V(CMP_Q1) VAL=1.65 RISE=1 TD=10.059m TARG V(GPIO_J5) VAL=1.65 RISE=1 TD=10.059m
.tran 1u 10.07m 0 2u
.end
